.SUBCKT FILL1BWP7T VDD VSS

.ENDS

.SUBCKT FILL2BWP7T VDD VSS

.ENDS

.SUBCKT FILL4BWP7T VDD VSS

.ENDS

.SUBCKT FILL8BWP7T VDD VSS

.ENDS

.SUBCKT FILL16BWP7T VDD VSS

.ENDS

.SUBCKT FILL32BWP7T VDD VSS

.ENDS

.SUBCKT TAPCELLBWP7T VDD VSS

.ENDS
